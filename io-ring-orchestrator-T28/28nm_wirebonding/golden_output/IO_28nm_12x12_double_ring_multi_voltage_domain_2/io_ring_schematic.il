pvdd3ac_h_gMaster = dbOpenCellView("tphn28hpcpgv18" "PVDD3AC_H_G" "symbol")
dbCreateInst(cv pvdd3ac_h_gMaster "AVDD_left0" '(0 24.8125) "R270")
schCreateWire(cv "route" "full" '((0.875 25.438) (1.625 25.438)) 0 0 0 nil nil)
schCreateWireLabel(cv nil '(1.125 25.438) "AVDD_CORE" "lowerLeft" "R0" "stick" 0.0625 nil)
schCreatePin(cv nil "AVDD_CORE" "inputOutput" nil '(1.625 25.438) "R180")
schCreateWire(cv "route" "full" '((0.875 25.062) (1.625 25.062)) 0 0 0 nil nil)
schCreateWireLabel(cv nil '(1.125 25.062) "AVSS" "lowerLeft" "R0" "stick" 0.0625 nil)
schCreateWire(cv "route" "full" '((0.875 24.688) (1.625 24.688)) 0 0 0 nil nil)
schCreateWireLabel(cv nil '(1.125 24.688) "GIOL" "lowerLeft" "R0" "stick" 0.0625 nil)
schCreateWire(cv "route" "full" '((0.000 25.000) (-0.750 25.000)) 0 0 0 nil nil)
schCreateWireLabel(cv nil '(-0.250 25.000) "AVDD" "lowerRight" "R0" "stick" 0.0625 nil)
schCreatePin(cv nil "AVDD" "inputOutput" nil '(-0.750 25.000) "R0")
pvss3ac_h_gMaster = dbOpenCellView("tphn28hpcpgv18" "PVSS3AC_H_G" "symbol")
dbCreateInst(cv pvss3ac_h_gMaster "AVSS_left1" '(0 22.8125) "R270")
schCreateWire(cv "route" "full" '((0.000 23.000) (-0.750 23.000)) 0 0 0 nil nil)
schCreateWireLabel(cv nil '(-0.250 23.000) "AVSS" "lowerRight" "R0" "stick" 0.0625 nil)
schCreatePin(cv nil "AVSS" "inputOutput" nil '(-0.750 23.000) "R0")
schCreateWire(cv "route" "full" '((0.875 22.688) (1.625 22.688)) 0 0 0 nil nil)
schCreateWireLabel(cv nil '(1.125 22.688) "GIOL" "lowerLeft" "R0" "stick" 0.0625 nil)
schCreateWire(cv "route" "full" '((0.875 23.438) (1.625 23.438)) 0 0 0 nil nil)
schCreateWireLabel(cv nil '(1.125 23.438) "AVSS_CORE" "lowerLeft" "R0" "stick" 0.0625 nil)
schCreatePin(cv nil "AVSS_CORE" "inputOutput" nil '(1.625 23.438) "R180")
schCreateWire(cv "route" "full" '((0.875 23.062) (1.625 23.062)) 0 0 0 nil nil)
schCreateWireLabel(cv nil '(1.125 23.062) "AVDD" "lowerLeft" "R0" "stick" 0.0625 nil)
pdb3ac_h_gMaster = dbOpenCellView("tphn28hpcpgv18" "PDB3AC_H_G" "symbol")
dbCreateInst(cv pdb3ac_h_gMaster "VIN_left2" '(0 20.8125) "R270")
schCreateWire(cv "route" "full" '((0.000 21.000) (-0.750 21.000)) 0 0 0 nil nil)
schCreateWireLabel(cv nil '(-0.250 21.000) "VIN" "lowerRight" "R0" "stick" 0.0625 nil)
schCreatePin(cv nil "VIN" "inputOutput" nil '(-0.750 21.000) "R0")
schCreateWire(cv "route" "full" '((0.875 21.062) (1.625 21.062)) 0 0 0 nil nil)
schCreateWireLabel(cv nil '(1.125 21.062) "AVSS" "lowerLeft" "R0" "stick" 0.0625 nil)
schCreateWire(cv "route" "full" '((0.875 20.688) (1.625 20.688)) 0 0 0 nil nil)
schCreateWireLabel(cv nil '(1.125 20.688) "GIOL" "lowerLeft" "R0" "stick" 0.0625 nil)
schCreateWire(cv "route" "full" '((0.875 21.438) (1.625 21.438)) 0 0 0 nil nil)
schCreateWireLabel(cv nil '(1.125 21.438) "AVDD" "lowerLeft" "R0" "stick" 0.0625 nil)
dbCreateInst(cv pdb3ac_h_gMaster "VIP_left3" '(0 18.8125) "R270")
schCreateWire(cv "route" "full" '((0.000 19.000) (-0.750 19.000)) 0 0 0 nil nil)
schCreateWireLabel(cv nil '(-0.250 19.000) "VIP" "lowerRight" "R0" "stick" 0.0625 nil)
schCreatePin(cv nil "VIP" "inputOutput" nil '(-0.750 19.000) "R0")
schCreateWire(cv "route" "full" '((0.875 19.062) (1.625 19.062)) 0 0 0 nil nil)
schCreateWireLabel(cv nil '(1.125 19.062) "AVSS" "lowerLeft" "R0" "stick" 0.0625 nil)
schCreateWire(cv "route" "full" '((0.875 18.688) (1.625 18.688)) 0 0 0 nil nil)
schCreateWireLabel(cv nil '(1.125 18.688) "GIOL" "lowerLeft" "R0" "stick" 0.0625 nil)
schCreateWire(cv "route" "full" '((0.875 19.438) (1.625 19.438)) 0 0 0 nil nil)
schCreateWireLabel(cv nil '(1.125 19.438) "AVDD" "lowerLeft" "R0" "stick" 0.0625 nil)
pvss1ac_h_gMaster = dbOpenCellView("tphn28hpcpgv18" "PVSS1AC_H_G" "symbol")
dbCreateInst(cv pvss1ac_h_gMaster "GND_left4" '(0 16.8125) "R270")
schCreateWire(cv "route" "full" '((0.000 17.000) (-0.750 17.000)) 0 0 0 nil nil)
schCreateWireLabel(cv nil '(-0.250 17.000) "GND" "lowerRight" "R0" "stick" 0.0625 nil)
schCreatePin(cv nil "GND" "inputOutput" nil '(-0.750 17.000) "R0")
schCreateWire(cv "route" "full" '((0.875 17.062) (1.625 17.062)) 0 0 0 nil nil)
schCreateWireLabel(cv nil '(1.125 17.062) "AVSS" "lowerLeft" "R0" "stick" 0.0625 nil)
schCreateWire(cv "route" "full" '((0.875 16.688) (1.625 16.688)) 0 0 0 nil nil)
schCreateWireLabel(cv nil '(1.125 16.688) "GIOL" "lowerLeft" "R0" "stick" 0.0625 nil)
schCreateWire(cv "route" "full" '((0.875 17.438) (1.625 17.438)) 0 0 0 nil nil)
schCreateWireLabel(cv nil '(1.125 17.438) "AVDD" "lowerLeft" "R0" "stick" 0.0625 nil)
dbCreateInst(cv pdb3ac_h_gMaster "VCM_left5" '(0 14.8125) "R270")
schCreateWire(cv "route" "full" '((0.000 15.001) (-0.750 15.001)) 0 0 0 nil nil)
schCreateWireLabel(cv nil '(-0.250 15.001) "VCM" "lowerRight" "R0" "stick" 0.0625 nil)
schCreatePin(cv nil "VCM" "inputOutput" nil '(-0.750 15.001) "R0")
schCreateWire(cv "route" "full" '((0.875 15.062) (1.625 15.062)) 0 0 0 nil nil)
schCreateWireLabel(cv nil '(1.125 15.062) "AVSS" "lowerLeft" "R0" "stick" 0.0625 nil)
schCreateWire(cv "route" "full" '((0.875 14.688) (1.625 14.688)) 0 0 0 nil nil)
schCreateWireLabel(cv nil '(1.125 14.688) "GIOL" "lowerLeft" "R0" "stick" 0.0625 nil)
schCreateWire(cv "route" "full" '((0.875 15.438) (1.625 15.438)) 0 0 0 nil nil)
schCreateWireLabel(cv nil '(1.125 15.438) "AVDD" "lowerLeft" "R0" "stick" 0.0625 nil)
dbCreateInst(cv pdb3ac_h_gMaster "VCM2_left6" '(0 12.8125) "R270")
schCreateWire(cv "route" "full" '((0.000 13.001) (-0.750 13.001)) 0 0 0 nil nil)
schCreateWireLabel(cv nil '(-0.250 13.001) "VCM2" "lowerRight" "R0" "stick" 0.0625 nil)
schCreatePin(cv nil "VCM2" "inputOutput" nil '(-0.750 13.001) "R0")
schCreateWire(cv "route" "full" '((0.875 13.062) (1.625 13.062)) 0 0 0 nil nil)
schCreateWireLabel(cv nil '(1.125 13.062) "AVSS" "lowerLeft" "R0" "stick" 0.0625 nil)
schCreateWire(cv "route" "full" '((0.875 12.688) (1.625 12.688)) 0 0 0 nil nil)
schCreateWireLabel(cv nil '(1.125 12.688) "GIOL" "lowerLeft" "R0" "stick" 0.0625 nil)
schCreateWire(cv "route" "full" '((0.875 13.438) (1.625 13.438)) 0 0 0 nil nil)
schCreateWireLabel(cv nil '(1.125 13.438) "AVDD" "lowerLeft" "R0" "stick" 0.0625 nil)
dbCreateInst(cv pdb3ac_h_gMaster "VCM3_left7" '(0 10.8125) "R270")
schCreateWire(cv "route" "full" '((0.000 11.001) (-0.750 11.001)) 0 0 0 nil nil)
schCreateWireLabel(cv nil '(-0.250 11.001) "VCM3" "lowerRight" "R0" "stick" 0.0625 nil)
schCreatePin(cv nil "VCM3" "inputOutput" nil '(-0.750 11.001) "R0")
schCreateWire(cv "route" "full" '((0.875 11.062) (1.625 11.062)) 0 0 0 nil nil)
schCreateWireLabel(cv nil '(1.125 11.062) "AVSS" "lowerLeft" "R0" "stick" 0.0625 nil)
schCreateWire(cv "route" "full" '((0.875 10.688) (1.625 10.688)) 0 0 0 nil nil)
schCreateWireLabel(cv nil '(1.125 10.688) "GIOL" "lowerLeft" "R0" "stick" 0.0625 nil)
schCreateWire(cv "route" "full" '((0.875 11.438) (1.625 11.438)) 0 0 0 nil nil)
schCreateWireLabel(cv nil '(1.125 11.438) "AVDD" "lowerLeft" "R0" "stick" 0.0625 nil)
dbCreateInst(cv pdb3ac_h_gMaster "IBREF_left8" '(0 8.8125) "R270")
schCreateWire(cv "route" "full" '((0.000 9.001) (-0.750 9.001)) 0 0 0 nil nil)
schCreateWireLabel(cv nil '(-0.250 9.001) "IBREF" "lowerRight" "R0" "stick" 0.0625 nil)
schCreatePin(cv nil "IBREF" "inputOutput" nil '(-0.750 9.001) "R0")
schCreateWire(cv "route" "full" '((0.875 9.062) (1.625 9.062)) 0 0 0 nil nil)
schCreateWireLabel(cv nil '(1.125 9.062) "AVSS" "lowerLeft" "R0" "stick" 0.0625 nil)
schCreateWire(cv "route" "full" '((0.875 8.688) (1.625 8.688)) 0 0 0 nil nil)
schCreateWireLabel(cv nil '(1.125 8.688) "GIOL" "lowerLeft" "R0" "stick" 0.0625 nil)
schCreateWire(cv "route" "full" '((0.875 9.438) (1.625 9.438)) 0 0 0 nil nil)
schCreateWireLabel(cv nil '(1.125 9.438) "AVDD" "lowerLeft" "R0" "stick" 0.0625 nil)
dbCreateInst(cv pdb3ac_h_gMaster "IBREF2_left9" '(0 6.8125) "R270")
schCreateWire(cv "route" "full" '((0.000 7.000) (-0.750 7.000)) 0 0 0 nil nil)
schCreateWireLabel(cv nil '(-0.250 7.000) "IBREF2" "lowerRight" "R0" "stick" 0.0625 nil)
schCreatePin(cv nil "IBREF2" "inputOutput" nil '(-0.750 7.000) "R0")
schCreateWire(cv "route" "full" '((0.875 7.062) (1.625 7.062)) 0 0 0 nil nil)
schCreateWireLabel(cv nil '(1.125 7.062) "AVSS" "lowerLeft" "R0" "stick" 0.0625 nil)
schCreateWire(cv "route" "full" '((0.875 6.688) (1.625 6.688)) 0 0 0 nil nil)
schCreateWireLabel(cv nil '(1.125 6.688) "GIOL" "lowerLeft" "R0" "stick" 0.0625 nil)
schCreateWire(cv "route" "full" '((0.875 7.438) (1.625 7.438)) 0 0 0 nil nil)
schCreateWireLabel(cv nil '(1.125 7.438) "AVDD" "lowerLeft" "R0" "stick" 0.0625 nil)
dbCreateInst(cv pdb3ac_h_gMaster "IBVIAS_left10" '(0 4.8125) "R270")
schCreateWire(cv "route" "full" '((0.000 5.000) (-0.750 5.000)) 0 0 0 nil nil)
schCreateWireLabel(cv nil '(-0.250 5.000) "IBVIAS" "lowerRight" "R0" "stick" 0.0625 nil)
schCreatePin(cv nil "IBVIAS" "inputOutput" nil '(-0.750 5.000) "R0")
schCreateWire(cv "route" "full" '((0.875 5.062) (1.625 5.062)) 0 0 0 nil nil)
schCreateWireLabel(cv nil '(1.125 5.062) "AVSS" "lowerLeft" "R0" "stick" 0.0625 nil)
schCreateWire(cv "route" "full" '((0.875 4.688) (1.625 4.688)) 0 0 0 nil nil)
schCreateWireLabel(cv nil '(1.125 4.688) "GIOL" "lowerLeft" "R0" "stick" 0.0625 nil)
schCreateWire(cv "route" "full" '((0.875 5.438) (1.625 5.438)) 0 0 0 nil nil)
schCreateWireLabel(cv nil '(1.125 5.438) "AVDD" "lowerLeft" "R0" "stick" 0.0625 nil)
dbCreateInst(cv pdb3ac_h_gMaster "IBVIAS2_left11" '(0 2.8125) "R270")
schCreateWire(cv "route" "full" '((0.000 3.001) (-0.750 3.001)) 0 0 0 nil nil)
schCreateWireLabel(cv nil '(-0.250 3.001) "IBVIAS2" "lowerRight" "R0" "stick" 0.0625 nil)
schCreatePin(cv nil "IBVIAS2" "inputOutput" nil '(-0.750 3.001) "R0")
schCreateWire(cv "route" "full" '((0.875 3.062) (1.625 3.062)) 0 0 0 nil nil)
schCreateWireLabel(cv nil '(1.125 3.062) "AVSS" "lowerLeft" "R0" "stick" 0.0625 nil)
schCreateWire(cv "route" "full" '((0.875 2.688) (1.625 2.688)) 0 0 0 nil nil)
schCreateWireLabel(cv nil '(1.125 2.688) "GIOL" "lowerLeft" "R0" "stick" 0.0625 nil)
schCreateWire(cv "route" "full" '((0.875 3.438) (1.625 3.438)) 0 0 0 nil nil)
schCreateWireLabel(cv nil '(1.125 3.438) "AVDD" "lowerLeft" "R0" "stick" 0.0625 nil)
pdb3ac_v_gMaster = dbOpenCellView("tphn28hpcpgv18" "PDB3AC_V_G" "symbol")
dbCreateInst(cv pdb3ac_v_gMaster "VCM4_bottom0" '(3.1875 0) "R0")
schCreateWire(cv "route" "full" '((2.999 0.000) (2.999 -0.750)) 0 0 0 nil nil)
schCreateWireLabel(cv nil '(2.999 -0.250) "VCM4" "lowerRight" "R90" "stick" 0.0625 nil)
schCreatePin(cv nil "VCM4" "inputOutput" nil '(2.999 -0.750) "R90")
schCreateWire(cv "route" "full" '((2.938 0.875) (2.938 1.625)) 0 0 0 nil nil)
schCreateWireLabel(cv nil '(2.938 1.125) "AVSS" "lowerLeft" "R90" "stick" 0.0625 nil)
schCreateWire(cv "route" "full" '((3.312 0.875) (3.312 1.625)) 0 0 0 nil nil)
schCreateWireLabel(cv nil '(3.312 1.125) "GIOL" "lowerLeft" "R90" "stick" 0.0625 nil)
schCreateWire(cv "route" "full" '((2.562 0.875) (2.562 1.625)) 0 0 0 nil nil)
schCreateWireLabel(cv nil '(2.562 1.125) "AVDD" "lowerLeft" "R90" "stick" 0.0625 nil)
dbCreateInst(cv pdb3ac_v_gMaster "VCM5_bottom1" '(5.1875 0) "R0")
schCreateWire(cv "route" "full" '((5.000 0.000) (5.000 -0.750)) 0 0 0 nil nil)
schCreateWireLabel(cv nil '(5.000 -0.250) "VCM5" "lowerRight" "R90" "stick" 0.0625 nil)
schCreatePin(cv nil "VCM5" "inputOutput" nil '(5.000 -0.750) "R90")
schCreateWire(cv "route" "full" '((4.938 0.875) (4.938 1.625)) 0 0 0 nil nil)
schCreateWireLabel(cv nil '(4.938 1.125) "AVSS" "lowerLeft" "R90" "stick" 0.0625 nil)
schCreateWire(cv "route" "full" '((5.312 0.875) (5.312 1.625)) 0 0 0 nil nil)
schCreateWireLabel(cv nil '(5.312 1.125) "GIOL" "lowerLeft" "R90" "stick" 0.0625 nil)
schCreateWire(cv "route" "full" '((4.562 0.875) (4.562 1.625)) 0 0 0 nil nil)
schCreateWireLabel(cv nil '(4.562 1.125) "AVDD" "lowerLeft" "R90" "stick" 0.0625 nil)
dbCreateInst(cv pdb3ac_v_gMaster "VCM6_bottom2" '(7.1875 0) "R0")
schCreateWire(cv "route" "full" '((7.000 0.000) (7.000 -0.750)) 0 0 0 nil nil)
schCreateWireLabel(cv nil '(7.000 -0.250) "VCM6" "lowerRight" "R90" "stick" 0.0625 nil)
schCreatePin(cv nil "VCM6" "inputOutput" nil '(7.000 -0.750) "R90")
schCreateWire(cv "route" "full" '((6.938 0.875) (6.938 1.625)) 0 0 0 nil nil)
schCreateWireLabel(cv nil '(6.938 1.125) "AVSS" "lowerLeft" "R90" "stick" 0.0625 nil)
schCreateWire(cv "route" "full" '((7.312 0.875) (7.312 1.625)) 0 0 0 nil nil)
schCreateWireLabel(cv nil '(7.312 1.125) "GIOL" "lowerLeft" "R90" "stick" 0.0625 nil)
schCreateWire(cv "route" "full" '((6.562 0.875) (6.562 1.625)) 0 0 0 nil nil)
schCreateWireLabel(cv nil '(6.562 1.125) "AVDD" "lowerLeft" "R90" "stick" 0.0625 nil)
pvss3ac_v_gMaster = dbOpenCellView("tphn28hpcpgv18" "PVSS3AC_V_G" "symbol")
dbCreateInst(cv pvss3ac_v_gMaster "VSSIB_bottom3" '(9.1875 0) "R0")
schCreateWire(cv "route" "full" '((8.999 0.000) (8.999 -0.750)) 0 0 0 nil nil)
schCreateWireLabel(cv nil '(8.999 -0.250) "VSSIB" "lowerRight" "R90" "stick" 0.0625 nil)
schCreatePin(cv nil "VSSIB" "inputOutput" nil '(8.999 -0.750) "R90")
schCreateWire(cv "route" "full" '((9.312 0.875) (9.312 1.625)) 0 0 0 nil nil)
schCreateWireLabel(cv nil '(9.312 1.125) "GIOL" "lowerLeft" "R90" "stick" 0.0625 nil)
schCreateWire(cv "route" "full" '((8.562 0.875) (8.562 1.625)) 0 0 0 nil nil)
schCreateWireLabel(cv nil '(8.562 1.125) "VSSIB_CORE" "lowerLeft" "R90" "stick" 0.0625 nil)
schCreatePin(cv nil "VSSIB_CORE" "inputOutput" nil '(8.562 1.625) "R270")
schCreateWire(cv "route" "full" '((8.938 0.875) (8.938 1.625)) 0 0 0 nil nil)
schCreateWireLabel(cv nil '(8.938 1.125) "VDDIB" "lowerLeft" "R90" "stick" 0.0625 nil)
pvdd3ac_v_gMaster = dbOpenCellView("tphn28hpcpgv18" "PVDD3AC_V_G" "symbol")
dbCreateInst(cv pvdd3ac_v_gMaster "VDDIB_bottom4" '(11.1875 0) "R0")
schCreateWire(cv "route" "full" '((10.562 0.875) (10.562 1.625)) 0 0 0 nil nil)
schCreateWireLabel(cv nil '(10.562 1.125) "VDDIB_CORE" "lowerLeft" "R90" "stick" 0.0625 nil)
schCreatePin(cv nil "VDDIB_CORE" "inputOutput" nil '(10.562 1.625) "R270")
schCreateWire(cv "route" "full" '((10.938 0.875) (10.938 1.625)) 0 0 0 nil nil)
schCreateWireLabel(cv nil '(10.938 1.125) "VSSIB" "lowerLeft" "R90" "stick" 0.0625 nil)
schCreateWire(cv "route" "full" '((11.312 0.875) (11.312 1.625)) 0 0 0 nil nil)
schCreateWireLabel(cv nil '(11.312 1.125) "GIOL" "lowerLeft" "R90" "stick" 0.0625 nil)
schCreateWire(cv "route" "full" '((10.999 0.000) (10.999 -0.750)) 0 0 0 nil nil)
schCreateWireLabel(cv nil '(10.999 -0.250) "VDDIB" "lowerRight" "R90" "stick" 0.0625 nil)
schCreatePin(cv nil "VDDIB" "inputOutput" nil '(10.999 -0.750) "R90")
dbCreateInst(cv pdb3ac_v_gMaster "IB0_bottom5" '(13.1875 0) "R0")
schCreateWire(cv "route" "full" '((12.999 0.000) (12.999 -0.750)) 0 0 0 nil nil)
schCreateWireLabel(cv nil '(12.999 -0.250) "IB0" "lowerRight" "R90" "stick" 0.0625 nil)
schCreatePin(cv nil "IB0" "inputOutput" nil '(12.999 -0.750) "R90")
schCreateWire(cv "route" "full" '((12.938 0.875) (12.938 1.625)) 0 0 0 nil nil)
schCreateWireLabel(cv nil '(12.938 1.125) "VSSIB" "lowerLeft" "R90" "stick" 0.0625 nil)
schCreateWire(cv "route" "full" '((13.312 0.875) (13.312 1.625)) 0 0 0 nil nil)
schCreateWireLabel(cv nil '(13.312 1.125) "GIOL" "lowerLeft" "R90" "stick" 0.0625 nil)
schCreateWire(cv "route" "full" '((12.562 0.875) (12.562 1.625)) 0 0 0 nil nil)
schCreateWireLabel(cv nil '(12.562 1.125) "VDDIB" "lowerLeft" "R90" "stick" 0.0625 nil)
dbCreateInst(cv pdb3ac_v_gMaster "IB1_bottom6" '(15.1875 0) "R0")
schCreateWire(cv "route" "full" '((14.999 0.000) (14.999 -0.750)) 0 0 0 nil nil)
schCreateWireLabel(cv nil '(14.999 -0.250) "IB1" "lowerRight" "R90" "stick" 0.0625 nil)
schCreatePin(cv nil "IB1" "inputOutput" nil '(14.999 -0.750) "R90")
schCreateWire(cv "route" "full" '((14.938 0.875) (14.938 1.625)) 0 0 0 nil nil)
schCreateWireLabel(cv nil '(14.938 1.125) "VSSIB" "lowerLeft" "R90" "stick" 0.0625 nil)
schCreateWire(cv "route" "full" '((15.312 0.875) (15.312 1.625)) 0 0 0 nil nil)
schCreateWireLabel(cv nil '(15.312 1.125) "GIOL" "lowerLeft" "R90" "stick" 0.0625 nil)
schCreateWire(cv "route" "full" '((14.562 0.875) (14.562 1.625)) 0 0 0 nil nil)
schCreateWireLabel(cv nil '(14.562 1.125) "VDDIB" "lowerLeft" "R90" "stick" 0.0625 nil)
dbCreateInst(cv pdb3ac_v_gMaster "IB2_bottom7" '(17.1875 0) "R0")
schCreateWire(cv "route" "full" '((17.000 0.000) (17.000 -0.750)) 0 0 0 nil nil)
schCreateWireLabel(cv nil '(17.000 -0.250) "IB2" "lowerRight" "R90" "stick" 0.0625 nil)
schCreatePin(cv nil "IB2" "inputOutput" nil '(17.000 -0.750) "R90")
schCreateWire(cv "route" "full" '((16.938 0.875) (16.938 1.625)) 0 0 0 nil nil)
schCreateWireLabel(cv nil '(16.938 1.125) "VSSIB" "lowerLeft" "R90" "stick" 0.0625 nil)
schCreateWire(cv "route" "full" '((17.312 0.875) (17.312 1.625)) 0 0 0 nil nil)
schCreateWireLabel(cv nil '(17.312 1.125) "GIOL" "lowerLeft" "R90" "stick" 0.0625 nil)
schCreateWire(cv "route" "full" '((16.562 0.875) (16.562 1.625)) 0 0 0 nil nil)
schCreateWireLabel(cv nil '(16.562 1.125) "VDDIB" "lowerLeft" "R90" "stick" 0.0625 nil)
dbCreateInst(cv pdb3ac_v_gMaster "IB3_bottom8" '(19.1875 0) "R0")
schCreateWire(cv "route" "full" '((19.000 0.000) (19.000 -0.750)) 0 0 0 nil nil)
schCreateWireLabel(cv nil '(19.000 -0.250) "IB3" "lowerRight" "R90" "stick" 0.0625 nil)
schCreatePin(cv nil "IB3" "inputOutput" nil '(19.000 -0.750) "R90")
schCreateWire(cv "route" "full" '((18.938 0.875) (18.938 1.625)) 0 0 0 nil nil)
schCreateWireLabel(cv nil '(18.938 1.125) "VSSIB" "lowerLeft" "R90" "stick" 0.0625 nil)
schCreateWire(cv "route" "full" '((19.312 0.875) (19.312 1.625)) 0 0 0 nil nil)
schCreateWireLabel(cv nil '(19.312 1.125) "GIOL" "lowerLeft" "R90" "stick" 0.0625 nil)
schCreateWire(cv "route" "full" '((18.562 0.875) (18.562 1.625)) 0 0 0 nil nil)
schCreateWireLabel(cv nil '(18.562 1.125) "VDDIB" "lowerLeft" "R90" "stick" 0.0625 nil)
dbCreateInst(cv pdb3ac_v_gMaster "IB4_bottom9" '(21.1875 0) "R0")
schCreateWire(cv "route" "full" '((21.000 0.000) (21.000 -0.750)) 0 0 0 nil nil)
schCreateWireLabel(cv nil '(21.000 -0.250) "IB4" "lowerRight" "R90" "stick" 0.0625 nil)
schCreatePin(cv nil "IB4" "inputOutput" nil '(21.000 -0.750) "R90")
schCreateWire(cv "route" "full" '((20.938 0.875) (20.938 1.625)) 0 0 0 nil nil)
schCreateWireLabel(cv nil '(20.938 1.125) "VSSIB" "lowerLeft" "R90" "stick" 0.0625 nil)
schCreateWire(cv "route" "full" '((21.312 0.875) (21.312 1.625)) 0 0 0 nil nil)
schCreateWireLabel(cv nil '(21.312 1.125) "GIOL" "lowerLeft" "R90" "stick" 0.0625 nil)
schCreateWire(cv "route" "full" '((20.562 0.875) (20.562 1.625)) 0 0 0 nil nil)
schCreateWireLabel(cv nil '(20.562 1.125) "VDDIB" "lowerLeft" "R90" "stick" 0.0625 nil)
dbCreateInst(cv pdb3ac_v_gMaster "IB5_bottom10" '(23.1875 0) "R0")
schCreateWire(cv "route" "full" '((23.000 0.000) (23.000 -0.750)) 0 0 0 nil nil)
schCreateWireLabel(cv nil '(23.000 -0.250) "IB5" "lowerRight" "R90" "stick" 0.0625 nil)
schCreatePin(cv nil "IB5" "inputOutput" nil '(23.000 -0.750) "R90")
schCreateWire(cv "route" "full" '((22.938 0.875) (22.938 1.625)) 0 0 0 nil nil)
schCreateWireLabel(cv nil '(22.938 1.125) "VSSIB" "lowerLeft" "R90" "stick" 0.0625 nil)
schCreateWire(cv "route" "full" '((23.312 0.875) (23.312 1.625)) 0 0 0 nil nil)
schCreateWireLabel(cv nil '(23.312 1.125) "GIOL" "lowerLeft" "R90" "stick" 0.0625 nil)
schCreateWire(cv "route" "full" '((22.562 0.875) (22.562 1.625)) 0 0 0 nil nil)
schCreateWireLabel(cv nil '(22.562 1.125) "VDDIB" "lowerLeft" "R90" "stick" 0.0625 nil)
dbCreateInst(cv pdb3ac_v_gMaster "IB6_bottom11" '(25.1875 0) "R0")
schCreateWire(cv "route" "full" '((25.000 0.000) (25.000 -0.750)) 0 0 0 nil nil)
schCreateWireLabel(cv nil '(25.000 -0.250) "IB6" "lowerRight" "R90" "stick" 0.0625 nil)
schCreatePin(cv nil "IB6" "inputOutput" nil '(25.000 -0.750) "R90")
schCreateWire(cv "route" "full" '((24.938 0.875) (24.938 1.625)) 0 0 0 nil nil)
schCreateWireLabel(cv nil '(24.938 1.125) "VSSIB" "lowerLeft" "R90" "stick" 0.0625 nil)
schCreateWire(cv "route" "full" '((25.312 0.875) (25.312 1.625)) 0 0 0 nil nil)
schCreateWireLabel(cv nil '(25.312 1.125) "GIOL" "lowerLeft" "R90" "stick" 0.0625 nil)
schCreateWire(cv "route" "full" '((24.562 0.875) (24.562 1.625)) 0 0 0 nil nil)
schCreateWireLabel(cv nil '(24.562 1.125) "VDDIB" "lowerLeft" "R90" "stick" 0.0625 nil)
dbCreateInst(cv pdb3ac_h_gMaster "IB7_right0" '(28.0 3.1875) "R90")
schCreateWire(cv "route" "full" '((28.000 2.999) (28.750 2.999)) 0 0 0 nil nil)
schCreateWireLabel(cv nil '(28.250 2.999) "IB7" "lowerLeft" "R0" "stick" 0.0625 nil)
schCreatePin(cv nil "IB7" "inputOutput" nil '(28.750 2.999) "R180")
schCreateWire(cv "route" "full" '((27.125 2.938) (26.375 2.938)) 0 0 0 nil nil)
schCreateWireLabel(cv nil '(26.875 2.938) "VSSIB" "lowerRight" "R0" "stick" 0.0625 nil)
schCreateWire(cv "route" "full" '((27.125 3.312) (26.375 3.312)) 0 0 0 nil nil)
schCreateWireLabel(cv nil '(26.875 3.312) "GIOL" "lowerRight" "R0" "stick" 0.0625 nil)
schCreateWire(cv "route" "full" '((27.125 2.562) (26.375 2.562)) 0 0 0 nil nil)
schCreateWireLabel(cv nil '(26.875 2.562) "VDDIB" "lowerRight" "R0" "stick" 0.0625 nil)
pddw16sdgz_h_gMaster = dbOpenCellView("tphn28hpcpgv18" "PDDW16SDGZ_H_G" "symbol")
dbCreateInst(cv pddw16sdgz_h_gMaster "D0_right1" '(28.0 4.3125) "R90")
schCreateWire(cv "route" "full" '((27.000 4.438) (26.250 4.438)) 0 0 0 nil nil)
schCreateWireLabel(cv nil '(26.750 4.438) "VIOL" "lowerRight" "R0" "stick" 0.0625 nil)
noConnMaster = dbOpenCellView("basic" "noConn" "symbol")
schCreateWire(cv "route" "full" '((27.000 4.562) (26.250 4.562)) 0 0 0 nil nil)
dbCreateInst(cv noConnMaster "noConn_D0_right1_C" '(26.250 4.562) "R270")
schCreateWire(cv "route" "full" '((27.000 4.188) (26.250 4.188)) 0 0 0 nil nil)
schCreateWireLabel(cv nil '(26.750 4.188) "GIOL" "lowerRight" "R0" "stick" 0.0625 nil)
schCreateWire(cv "route" "full" '((27.000 4.062) (26.250 4.062)) 0 0 0 nil nil)
schCreateWireLabel(cv nil '(26.750 4.062) "D0_CORE" "lowerRight" "R0" "stick" 0.0625 nil)
schCreatePin(cv nil "D0_CORE" "inputOutput" nil '(26.250 4.062) "R0")
schCreateWire(cv "route" "full" '((28.000 5.000) (28.750 5.000)) 0 0 0 nil nil)
schCreateWireLabel(cv nil '(28.250 5.000) "D0" "lowerLeft" "R0" "stick" 0.0625 nil)
schCreatePin(cv nil "D0" "inputOutput" nil '(28.750 5.000) "R180")
schCreateWire(cv "route" "full" '((27.000 4.688) (26.250 4.688)) 0 0 0 nil nil)
schCreateWireLabel(cv nil '(26.750 4.688) "POC" "lowerRight" "R0" "stick" 0.0625 nil)
schCreateWire(cv "route" "full" '((27.000 4.875) (26.250 4.875)) 0 0 0 nil nil)
schCreateWireLabel(cv nil '(26.750 4.875) "VIOL" "lowerRight" "R0" "stick" 0.0625 nil)
schCreateWire(cv "route" "full" '((27.000 5.062) (26.250 5.062)) 0 0 0 nil nil)
schCreateWireLabel(cv nil '(26.750 5.062) "GIOL" "lowerRight" "R0" "stick" 0.0625 nil)
schCreateWire(cv "route" "full" '((27.000 5.250) (26.250 5.250)) 0 0 0 nil nil)
schCreateWireLabel(cv nil '(26.750 5.250) "VIOH" "lowerRight" "R0" "stick" 0.0625 nil)
schCreateWire(cv "route" "full" '((27.000 5.625) (26.250 5.625)) 0 0 0 nil nil)
schCreateWireLabel(cv nil '(26.750 5.625) "GIOH" "lowerRight" "R0" "stick" 0.0625 nil)
dbCreateInst(cv pddw16sdgz_h_gMaster "D1_right2" '(28.0 6.3125) "R90")
schCreateWire(cv "route" "full" '((27.000 6.438) (26.250 6.438)) 0 0 0 nil nil)
schCreateWireLabel(cv nil '(26.750 6.438) "VIOL" "lowerRight" "R0" "stick" 0.0625 nil)
schCreateWire(cv "route" "full" '((27.000 6.562) (26.250 6.562)) 0 0 0 nil nil)
dbCreateInst(cv noConnMaster "noConn_D1_right2_C" '(26.250 6.562) "R270")
schCreateWire(cv "route" "full" '((27.000 6.188) (26.250 6.188)) 0 0 0 nil nil)
schCreateWireLabel(cv nil '(26.750 6.188) "GIOL" "lowerRight" "R0" "stick" 0.0625 nil)
schCreateWire(cv "route" "full" '((27.000 6.062) (26.250 6.062)) 0 0 0 nil nil)
schCreateWireLabel(cv nil '(26.750 6.062) "D1_CORE" "lowerRight" "R0" "stick" 0.0625 nil)
schCreatePin(cv nil "D1_CORE" "inputOutput" nil '(26.250 6.062) "R0")
schCreateWire(cv "route" "full" '((28.000 7.000) (28.750 7.000)) 0 0 0 nil nil)
schCreateWireLabel(cv nil '(28.250 7.000) "D1" "lowerLeft" "R0" "stick" 0.0625 nil)
schCreatePin(cv nil "D1" "inputOutput" nil '(28.750 7.000) "R180")
schCreateWire(cv "route" "full" '((27.000 6.688) (26.250 6.688)) 0 0 0 nil nil)
schCreateWireLabel(cv nil '(26.750 6.688) "POC" "lowerRight" "R0" "stick" 0.0625 nil)
schCreateWire(cv "route" "full" '((27.000 6.875) (26.250 6.875)) 0 0 0 nil nil)
schCreateWireLabel(cv nil '(26.750 6.875) "VIOL" "lowerRight" "R0" "stick" 0.0625 nil)
schCreateWire(cv "route" "full" '((27.000 7.062) (26.250 7.062)) 0 0 0 nil nil)
schCreateWireLabel(cv nil '(26.750 7.062) "GIOL" "lowerRight" "R0" "stick" 0.0625 nil)
schCreateWire(cv "route" "full" '((27.000 7.250) (26.250 7.250)) 0 0 0 nil nil)
schCreateWireLabel(cv nil '(26.750 7.250) "VIOH" "lowerRight" "R0" "stick" 0.0625 nil)
schCreateWire(cv "route" "full" '((27.000 7.625) (26.250 7.625)) 0 0 0 nil nil)
schCreateWireLabel(cv nil '(26.750 7.625) "GIOH" "lowerRight" "R0" "stick" 0.0625 nil)
dbCreateInst(cv pddw16sdgz_h_gMaster "D2_right3" '(28.0 8.3125) "R90")
schCreateWire(cv "route" "full" '((27.000 8.438) (26.250 8.438)) 0 0 0 nil nil)
schCreateWireLabel(cv nil '(26.750 8.438) "VIOL" "lowerRight" "R0" "stick" 0.0625 nil)
schCreateWire(cv "route" "full" '((27.000 8.562) (26.250 8.562)) 0 0 0 nil nil)
dbCreateInst(cv noConnMaster "noConn_D2_right3_C" '(26.250 8.562) "R270")
schCreateWire(cv "route" "full" '((27.000 8.188) (26.250 8.188)) 0 0 0 nil nil)
schCreateWireLabel(cv nil '(26.750 8.188) "GIOL" "lowerRight" "R0" "stick" 0.0625 nil)
schCreateWire(cv "route" "full" '((27.000 8.062) (26.250 8.062)) 0 0 0 nil nil)
schCreateWireLabel(cv nil '(26.750 8.062) "D2_CORE" "lowerRight" "R0" "stick" 0.0625 nil)
schCreatePin(cv nil "D2_CORE" "inputOutput" nil '(26.250 8.062) "R0")
schCreateWire(cv "route" "full" '((28.000 9.001) (28.750 9.001)) 0 0 0 nil nil)
schCreateWireLabel(cv nil '(28.250 9.001) "D2" "lowerLeft" "R0" "stick" 0.0625 nil)
schCreatePin(cv nil "D2" "inputOutput" nil '(28.750 9.001) "R180")
schCreateWire(cv "route" "full" '((27.000 8.688) (26.250 8.688)) 0 0 0 nil nil)
schCreateWireLabel(cv nil '(26.750 8.688) "POC" "lowerRight" "R0" "stick" 0.0625 nil)
schCreateWire(cv "route" "full" '((27.000 8.874) (26.250 8.874)) 0 0 0 nil nil)
schCreateWireLabel(cv nil '(26.750 8.874) "VIOL" "lowerRight" "R0" "stick" 0.0625 nil)
schCreateWire(cv "route" "full" '((27.000 9.062) (26.250 9.062)) 0 0 0 nil nil)
schCreateWireLabel(cv nil '(26.750 9.062) "GIOL" "lowerRight" "R0" "stick" 0.0625 nil)
schCreateWire(cv "route" "full" '((27.000 9.251) (26.250 9.251)) 0 0 0 nil nil)
schCreateWireLabel(cv nil '(26.750 9.251) "VIOH" "lowerRight" "R0" "stick" 0.0625 nil)
schCreateWire(cv "route" "full" '((27.000 9.624) (26.250 9.624)) 0 0 0 nil nil)
schCreateWireLabel(cv nil '(26.750 9.624) "GIOH" "lowerRight" "R0" "stick" 0.0625 nil)
dbCreateInst(cv pddw16sdgz_h_gMaster "D3_right4" '(28.0 10.3125) "R90")
schCreateWire(cv "route" "full" '((27.000 10.438) (26.250 10.438)) 0 0 0 nil nil)
schCreateWireLabel(cv nil '(26.750 10.438) "VIOL" "lowerRight" "R0" "stick" 0.0625 nil)
schCreateWire(cv "route" "full" '((27.000 10.562) (26.250 10.562)) 0 0 0 nil nil)
dbCreateInst(cv noConnMaster "noConn_D3_right4_C" '(26.250 10.562) "R270")
schCreateWire(cv "route" "full" '((27.000 10.188) (26.250 10.188)) 0 0 0 nil nil)
schCreateWireLabel(cv nil '(26.750 10.188) "GIOL" "lowerRight" "R0" "stick" 0.0625 nil)
schCreateWire(cv "route" "full" '((27.000 10.062) (26.250 10.062)) 0 0 0 nil nil)
schCreateWireLabel(cv nil '(26.750 10.062) "D3_CORE" "lowerRight" "R0" "stick" 0.0625 nil)
schCreatePin(cv nil "D3_CORE" "inputOutput" nil '(26.250 10.062) "R0")
schCreateWire(cv "route" "full" '((28.000 11.001) (28.750 11.001)) 0 0 0 nil nil)
schCreateWireLabel(cv nil '(28.250 11.001) "D3" "lowerLeft" "R0" "stick" 0.0625 nil)
schCreatePin(cv nil "D3" "inputOutput" nil '(28.750 11.001) "R180")
schCreateWire(cv "route" "full" '((27.000 10.688) (26.250 10.688)) 0 0 0 nil nil)
schCreateWireLabel(cv nil '(26.750 10.688) "POC" "lowerRight" "R0" "stick" 0.0625 nil)
schCreateWire(cv "route" "full" '((27.000 10.874) (26.250 10.874)) 0 0 0 nil nil)
schCreateWireLabel(cv nil '(26.750 10.874) "VIOL" "lowerRight" "R0" "stick" 0.0625 nil)
schCreateWire(cv "route" "full" '((27.000 11.062) (26.250 11.062)) 0 0 0 nil nil)
schCreateWireLabel(cv nil '(26.750 11.062) "GIOL" "lowerRight" "R0" "stick" 0.0625 nil)
schCreateWire(cv "route" "full" '((27.000 11.251) (26.250 11.251)) 0 0 0 nil nil)
schCreateWireLabel(cv nil '(26.750 11.251) "VIOH" "lowerRight" "R0" "stick" 0.0625 nil)
schCreateWire(cv "route" "full" '((27.000 11.624) (26.250 11.624)) 0 0 0 nil nil)
schCreateWireLabel(cv nil '(26.750 11.624) "GIOH" "lowerRight" "R0" "stick" 0.0625 nil)
dbCreateInst(cv pddw16sdgz_h_gMaster "D4_right5" '(28.0 12.3125) "R90")
schCreateWire(cv "route" "full" '((27.000 12.438) (26.250 12.438)) 0 0 0 nil nil)
schCreateWireLabel(cv nil '(26.750 12.438) "VIOL" "lowerRight" "R0" "stick" 0.0625 nil)
schCreateWire(cv "route" "full" '((27.000 12.562) (26.250 12.562)) 0 0 0 nil nil)
dbCreateInst(cv noConnMaster "noConn_D4_right5_C" '(26.250 12.562) "R270")
schCreateWire(cv "route" "full" '((27.000 12.188) (26.250 12.188)) 0 0 0 nil nil)
schCreateWireLabel(cv nil '(26.750 12.188) "GIOL" "lowerRight" "R0" "stick" 0.0625 nil)
schCreateWire(cv "route" "full" '((27.000 12.062) (26.250 12.062)) 0 0 0 nil nil)
schCreateWireLabel(cv nil '(26.750 12.062) "D4_CORE" "lowerRight" "R0" "stick" 0.0625 nil)
schCreatePin(cv nil "D4_CORE" "inputOutput" nil '(26.250 12.062) "R0")
schCreateWire(cv "route" "full" '((28.000 13.001) (28.750 13.001)) 0 0 0 nil nil)
schCreateWireLabel(cv nil '(28.250 13.001) "D4" "lowerLeft" "R0" "stick" 0.0625 nil)
schCreatePin(cv nil "D4" "inputOutput" nil '(28.750 13.001) "R180")
schCreateWire(cv "route" "full" '((27.000 12.688) (26.250 12.688)) 0 0 0 nil nil)
schCreateWireLabel(cv nil '(26.750 12.688) "POC" "lowerRight" "R0" "stick" 0.0625 nil)
schCreateWire(cv "route" "full" '((27.000 12.874) (26.250 12.874)) 0 0 0 nil nil)
schCreateWireLabel(cv nil '(26.750 12.874) "VIOL" "lowerRight" "R0" "stick" 0.0625 nil)
schCreateWire(cv "route" "full" '((27.000 13.062) (26.250 13.062)) 0 0 0 nil nil)
schCreateWireLabel(cv nil '(26.750 13.062) "GIOL" "lowerRight" "R0" "stick" 0.0625 nil)
schCreateWire(cv "route" "full" '((27.000 13.251) (26.250 13.251)) 0 0 0 nil nil)
schCreateWireLabel(cv nil '(26.750 13.251) "VIOH" "lowerRight" "R0" "stick" 0.0625 nil)
schCreateWire(cv "route" "full" '((27.000 13.624) (26.250 13.624)) 0 0 0 nil nil)
schCreateWireLabel(cv nil '(26.750 13.624) "GIOH" "lowerRight" "R0" "stick" 0.0625 nil)
dbCreateInst(cv pddw16sdgz_h_gMaster "D5_right6" '(28.0 14.3125) "R90")
schCreateWire(cv "route" "full" '((27.000 14.438) (26.250 14.438)) 0 0 0 nil nil)
schCreateWireLabel(cv nil '(26.750 14.438) "VIOL" "lowerRight" "R0" "stick" 0.0625 nil)
schCreateWire(cv "route" "full" '((27.000 14.562) (26.250 14.562)) 0 0 0 nil nil)
dbCreateInst(cv noConnMaster "noConn_D5_right6_C" '(26.250 14.562) "R270")
schCreateWire(cv "route" "full" '((27.000 14.188) (26.250 14.188)) 0 0 0 nil nil)
schCreateWireLabel(cv nil '(26.750 14.188) "GIOL" "lowerRight" "R0" "stick" 0.0625 nil)
schCreateWire(cv "route" "full" '((27.000 14.062) (26.250 14.062)) 0 0 0 nil nil)
schCreateWireLabel(cv nil '(26.750 14.062) "D5_CORE" "lowerRight" "R0" "stick" 0.0625 nil)
schCreatePin(cv nil "D5_CORE" "inputOutput" nil '(26.250 14.062) "R0")
schCreateWire(cv "route" "full" '((28.000 15.001) (28.750 15.001)) 0 0 0 nil nil)
schCreateWireLabel(cv nil '(28.250 15.001) "D5" "lowerLeft" "R0" "stick" 0.0625 nil)
schCreatePin(cv nil "D5" "inputOutput" nil '(28.750 15.001) "R180")
schCreateWire(cv "route" "full" '((27.000 14.688) (26.250 14.688)) 0 0 0 nil nil)
schCreateWireLabel(cv nil '(26.750 14.688) "POC" "lowerRight" "R0" "stick" 0.0625 nil)
schCreateWire(cv "route" "full" '((27.000 14.874) (26.250 14.874)) 0 0 0 nil nil)
schCreateWireLabel(cv nil '(26.750 14.874) "VIOL" "lowerRight" "R0" "stick" 0.0625 nil)
schCreateWire(cv "route" "full" '((27.000 15.062) (26.250 15.062)) 0 0 0 nil nil)
schCreateWireLabel(cv nil '(26.750 15.062) "GIOL" "lowerRight" "R0" "stick" 0.0625 nil)
schCreateWire(cv "route" "full" '((27.000 15.251) (26.250 15.251)) 0 0 0 nil nil)
schCreateWireLabel(cv nil '(26.750 15.251) "VIOH" "lowerRight" "R0" "stick" 0.0625 nil)
schCreateWire(cv "route" "full" '((27.000 15.624) (26.250 15.624)) 0 0 0 nil nil)
schCreateWireLabel(cv nil '(26.750 15.624) "GIOH" "lowerRight" "R0" "stick" 0.0625 nil)
dbCreateInst(cv pddw16sdgz_h_gMaster "D6_right7" '(28.0 16.3125) "R90")
schCreateWire(cv "route" "full" '((27.000 16.438) (26.250 16.438)) 0 0 0 nil nil)
schCreateWireLabel(cv nil '(26.750 16.438) "VIOL" "lowerRight" "R0" "stick" 0.0625 nil)
schCreateWire(cv "route" "full" '((27.000 16.562) (26.250 16.562)) 0 0 0 nil nil)
dbCreateInst(cv noConnMaster "noConn_D6_right7_C" '(26.250 16.562) "R270")
schCreateWire(cv "route" "full" '((27.000 16.188) (26.250 16.188)) 0 0 0 nil nil)
schCreateWireLabel(cv nil '(26.750 16.188) "GIOL" "lowerRight" "R0" "stick" 0.0625 nil)
schCreateWire(cv "route" "full" '((27.000 16.062) (26.250 16.062)) 0 0 0 nil nil)
schCreateWireLabel(cv nil '(26.750 16.062) "D6_CORE" "lowerRight" "R0" "stick" 0.0625 nil)
schCreatePin(cv nil "D6_CORE" "inputOutput" nil '(26.250 16.062) "R0")
schCreateWire(cv "route" "full" '((28.000 17.000) (28.750 17.000)) 0 0 0 nil nil)
schCreateWireLabel(cv nil '(28.250 17.000) "D6" "lowerLeft" "R0" "stick" 0.0625 nil)
schCreatePin(cv nil "D6" "inputOutput" nil '(28.750 17.000) "R180")
schCreateWire(cv "route" "full" '((27.000 16.688) (26.250 16.688)) 0 0 0 nil nil)
schCreateWireLabel(cv nil '(26.750 16.688) "POC" "lowerRight" "R0" "stick" 0.0625 nil)
schCreateWire(cv "route" "full" '((27.000 16.875) (26.250 16.875)) 0 0 0 nil nil)
schCreateWireLabel(cv nil '(26.750 16.875) "VIOL" "lowerRight" "R0" "stick" 0.0625 nil)
schCreateWire(cv "route" "full" '((27.000 17.062) (26.250 17.062)) 0 0 0 nil nil)
schCreateWireLabel(cv nil '(26.750 17.062) "GIOL" "lowerRight" "R0" "stick" 0.0625 nil)
schCreateWire(cv "route" "full" '((27.000 17.250) (26.250 17.250)) 0 0 0 nil nil)
schCreateWireLabel(cv nil '(26.750 17.250) "VIOH" "lowerRight" "R0" "stick" 0.0625 nil)
schCreateWire(cv "route" "full" '((27.000 17.625) (26.250 17.625)) 0 0 0 nil nil)
schCreateWireLabel(cv nil '(26.750 17.625) "GIOH" "lowerRight" "R0" "stick" 0.0625 nil)
dbCreateInst(cv pddw16sdgz_h_gMaster "D7_right8" '(28.0 18.3125) "R90")
schCreateWire(cv "route" "full" '((27.000 18.438) (26.250 18.438)) 0 0 0 nil nil)
schCreateWireLabel(cv nil '(26.750 18.438) "VIOL" "lowerRight" "R0" "stick" 0.0625 nil)
schCreateWire(cv "route" "full" '((27.000 18.562) (26.250 18.562)) 0 0 0 nil nil)
dbCreateInst(cv noConnMaster "noConn_D7_right8_C" '(26.250 18.562) "R270")
schCreateWire(cv "route" "full" '((27.000 18.188) (26.250 18.188)) 0 0 0 nil nil)
schCreateWireLabel(cv nil '(26.750 18.188) "GIOL" "lowerRight" "R0" "stick" 0.0625 nil)
schCreateWire(cv "route" "full" '((27.000 18.062) (26.250 18.062)) 0 0 0 nil nil)
schCreateWireLabel(cv nil '(26.750 18.062) "D7_CORE" "lowerRight" "R0" "stick" 0.0625 nil)
schCreatePin(cv nil "D7_CORE" "inputOutput" nil '(26.250 18.062) "R0")
schCreateWire(cv "route" "full" '((28.000 19.000) (28.750 19.000)) 0 0 0 nil nil)
schCreateWireLabel(cv nil '(28.250 19.000) "D7" "lowerLeft" "R0" "stick" 0.0625 nil)
schCreatePin(cv nil "D7" "inputOutput" nil '(28.750 19.000) "R180")
schCreateWire(cv "route" "full" '((27.000 18.688) (26.250 18.688)) 0 0 0 nil nil)
schCreateWireLabel(cv nil '(26.750 18.688) "POC" "lowerRight" "R0" "stick" 0.0625 nil)
schCreateWire(cv "route" "full" '((27.000 18.875) (26.250 18.875)) 0 0 0 nil nil)
schCreateWireLabel(cv nil '(26.750 18.875) "VIOL" "lowerRight" "R0" "stick" 0.0625 nil)
schCreateWire(cv "route" "full" '((27.000 19.062) (26.250 19.062)) 0 0 0 nil nil)
schCreateWireLabel(cv nil '(26.750 19.062) "GIOL" "lowerRight" "R0" "stick" 0.0625 nil)
schCreateWire(cv "route" "full" '((27.000 19.250) (26.250 19.250)) 0 0 0 nil nil)
schCreateWireLabel(cv nil '(26.750 19.250) "VIOH" "lowerRight" "R0" "stick" 0.0625 nil)
schCreateWire(cv "route" "full" '((27.000 19.625) (26.250 19.625)) 0 0 0 nil nil)
schCreateWireLabel(cv nil '(26.750 19.625) "GIOH" "lowerRight" "R0" "stick" 0.0625 nil)
dbCreateInst(cv pddw16sdgz_h_gMaster "D8_right9" '(28.0 20.3125) "R90")
schCreateWire(cv "route" "full" '((27.000 20.438) (26.250 20.438)) 0 0 0 nil nil)
schCreateWireLabel(cv nil '(26.750 20.438) "VIOL" "lowerRight" "R0" "stick" 0.0625 nil)
schCreateWire(cv "route" "full" '((27.000 20.562) (26.250 20.562)) 0 0 0 nil nil)
dbCreateInst(cv noConnMaster "noConn_D8_right9_C" '(26.250 20.562) "R270")
schCreateWire(cv "route" "full" '((27.000 20.188) (26.250 20.188)) 0 0 0 nil nil)
schCreateWireLabel(cv nil '(26.750 20.188) "GIOL" "lowerRight" "R0" "stick" 0.0625 nil)
schCreateWire(cv "route" "full" '((27.000 20.062) (26.250 20.062)) 0 0 0 nil nil)
schCreateWireLabel(cv nil '(26.750 20.062) "D8_CORE" "lowerRight" "R0" "stick" 0.0625 nil)
schCreatePin(cv nil "D8_CORE" "inputOutput" nil '(26.250 20.062) "R0")
schCreateWire(cv "route" "full" '((28.000 21.000) (28.750 21.000)) 0 0 0 nil nil)
schCreateWireLabel(cv nil '(28.250 21.000) "D8" "lowerLeft" "R0" "stick" 0.0625 nil)
schCreatePin(cv nil "D8" "inputOutput" nil '(28.750 21.000) "R180")
schCreateWire(cv "route" "full" '((27.000 20.688) (26.250 20.688)) 0 0 0 nil nil)
schCreateWireLabel(cv nil '(26.750 20.688) "POC" "lowerRight" "R0" "stick" 0.0625 nil)
schCreateWire(cv "route" "full" '((27.000 20.875) (26.250 20.875)) 0 0 0 nil nil)
schCreateWireLabel(cv nil '(26.750 20.875) "VIOL" "lowerRight" "R0" "stick" 0.0625 nil)
schCreateWire(cv "route" "full" '((27.000 21.062) (26.250 21.062)) 0 0 0 nil nil)
schCreateWireLabel(cv nil '(26.750 21.062) "GIOL" "lowerRight" "R0" "stick" 0.0625 nil)
schCreateWire(cv "route" "full" '((27.000 21.250) (26.250 21.250)) 0 0 0 nil nil)
schCreateWireLabel(cv nil '(26.750 21.250) "VIOH" "lowerRight" "R0" "stick" 0.0625 nil)
schCreateWire(cv "route" "full" '((27.000 21.625) (26.250 21.625)) 0 0 0 nil nil)
schCreateWireLabel(cv nil '(26.750 21.625) "GIOH" "lowerRight" "R0" "stick" 0.0625 nil)
dbCreateInst(cv pddw16sdgz_h_gMaster "D9_right10" '(28.0 22.3125) "R90")
schCreateWire(cv "route" "full" '((27.000 22.438) (26.250 22.438)) 0 0 0 nil nil)
schCreateWireLabel(cv nil '(26.750 22.438) "VIOL" "lowerRight" "R0" "stick" 0.0625 nil)
schCreateWire(cv "route" "full" '((27.000 22.562) (26.250 22.562)) 0 0 0 nil nil)
dbCreateInst(cv noConnMaster "noConn_D9_right10_C" '(26.250 22.562) "R270")
schCreateWire(cv "route" "full" '((27.000 22.188) (26.250 22.188)) 0 0 0 nil nil)
schCreateWireLabel(cv nil '(26.750 22.188) "GIOL" "lowerRight" "R0" "stick" 0.0625 nil)
schCreateWire(cv "route" "full" '((27.000 22.062) (26.250 22.062)) 0 0 0 nil nil)
schCreateWireLabel(cv nil '(26.750 22.062) "D9_CORE" "lowerRight" "R0" "stick" 0.0625 nil)
schCreatePin(cv nil "D9_CORE" "inputOutput" nil '(26.250 22.062) "R0")
schCreateWire(cv "route" "full" '((28.000 23.000) (28.750 23.000)) 0 0 0 nil nil)
schCreateWireLabel(cv nil '(28.250 23.000) "D9" "lowerLeft" "R0" "stick" 0.0625 nil)
schCreatePin(cv nil "D9" "inputOutput" nil '(28.750 23.000) "R180")
schCreateWire(cv "route" "full" '((27.000 22.688) (26.250 22.688)) 0 0 0 nil nil)
schCreateWireLabel(cv nil '(26.750 22.688) "POC" "lowerRight" "R0" "stick" 0.0625 nil)
schCreateWire(cv "route" "full" '((27.000 22.875) (26.250 22.875)) 0 0 0 nil nil)
schCreateWireLabel(cv nil '(26.750 22.875) "VIOL" "lowerRight" "R0" "stick" 0.0625 nil)
schCreateWire(cv "route" "full" '((27.000 23.062) (26.250 23.062)) 0 0 0 nil nil)
schCreateWireLabel(cv nil '(26.750 23.062) "GIOL" "lowerRight" "R0" "stick" 0.0625 nil)
schCreateWire(cv "route" "full" '((27.000 23.250) (26.250 23.250)) 0 0 0 nil nil)
schCreateWireLabel(cv nil '(26.750 23.250) "VIOH" "lowerRight" "R0" "stick" 0.0625 nil)
schCreateWire(cv "route" "full" '((27.000 23.625) (26.250 23.625)) 0 0 0 nil nil)
schCreateWireLabel(cv nil '(26.750 23.625) "GIOH" "lowerRight" "R0" "stick" 0.0625 nil)
dbCreateInst(cv pddw16sdgz_h_gMaster "D10_right11" '(28.0 24.3125) "R90")
schCreateWire(cv "route" "full" '((27.000 24.438) (26.250 24.438)) 0 0 0 nil nil)
schCreateWireLabel(cv nil '(26.750 24.438) "VIOL" "lowerRight" "R0" "stick" 0.0625 nil)
schCreateWire(cv "route" "full" '((27.000 24.562) (26.250 24.562)) 0 0 0 nil nil)
dbCreateInst(cv noConnMaster "noConn_D10_right11_C" '(26.250 24.562) "R270")
schCreateWire(cv "route" "full" '((27.000 24.188) (26.250 24.188)) 0 0 0 nil nil)
schCreateWireLabel(cv nil '(26.750 24.188) "GIOL" "lowerRight" "R0" "stick" 0.0625 nil)
schCreateWire(cv "route" "full" '((27.000 24.062) (26.250 24.062)) 0 0 0 nil nil)
schCreateWireLabel(cv nil '(26.750 24.062) "D10_CORE" "lowerRight" "R0" "stick" 0.0625 nil)
schCreatePin(cv nil "D10_CORE" "inputOutput" nil '(26.250 24.062) "R0")
schCreateWire(cv "route" "full" '((28.000 25.000) (28.750 25.000)) 0 0 0 nil nil)
schCreateWireLabel(cv nil '(28.250 25.000) "D10" "lowerLeft" "R0" "stick" 0.0625 nil)
schCreatePin(cv nil "D10" "inputOutput" nil '(28.750 25.000) "R180")
schCreateWire(cv "route" "full" '((27.000 24.688) (26.250 24.688)) 0 0 0 nil nil)
schCreateWireLabel(cv nil '(26.750 24.688) "POC" "lowerRight" "R0" "stick" 0.0625 nil)
schCreateWire(cv "route" "full" '((27.000 24.875) (26.250 24.875)) 0 0 0 nil nil)
schCreateWireLabel(cv nil '(26.750 24.875) "VIOL" "lowerRight" "R0" "stick" 0.0625 nil)
schCreateWire(cv "route" "full" '((27.000 25.062) (26.250 25.062)) 0 0 0 nil nil)
schCreateWireLabel(cv nil '(26.750 25.062) "GIOL" "lowerRight" "R0" "stick" 0.0625 nil)
schCreateWire(cv "route" "full" '((27.000 25.250) (26.250 25.250)) 0 0 0 nil nil)
schCreateWireLabel(cv nil '(26.750 25.250) "VIOH" "lowerRight" "R0" "stick" 0.0625 nil)
schCreateWire(cv "route" "full" '((27.000 25.625) (26.250 25.625)) 0 0 0 nil nil)
schCreateWireLabel(cv nil '(26.750 25.625) "GIOH" "lowerRight" "R0" "stick" 0.0625 nil)
pddw16sdgz_v_gMaster = dbOpenCellView("tphn28hpcpgv18" "PDDW16SDGZ_V_G" "symbol")
dbCreateInst(cv pddw16sdgz_v_gMaster "D11_top0" '(25.6875 28.0) "R180")
schCreateWire(cv "route" "full" '((25.562 27.000) (25.562 26.250)) 0 0 0 nil nil)
schCreateWireLabel(cv nil '(25.562 26.750) "VIOL" "lowerRight" "R90" "stick" 0.0625 nil)
schCreateWire(cv "route" "full" '((25.438 27.000) (25.438 26.250)) 0 0 0 nil nil)
dbCreateInst(cv noConnMaster "noConn_D11_top0_C" '(25.438 26.250) "R0")
schCreateWire(cv "route" "full" '((25.812 27.000) (25.812 26.250)) 0 0 0 nil nil)
schCreateWireLabel(cv nil '(25.812 26.750) "GIOL" "lowerRight" "R90" "stick" 0.0625 nil)
schCreateWire(cv "route" "full" '((25.938 27.000) (25.938 26.250)) 0 0 0 nil nil)
schCreateWireLabel(cv nil '(25.938 26.750) "D11_CORE" "lowerRight" "R90" "stick" 0.0625 nil)
schCreatePin(cv nil "D11_CORE" "inputOutput" nil '(25.938 26.250) "R90")
schCreateWire(cv "route" "full" '((25.000 28.000) (25.000 28.750)) 0 0 0 nil nil)
schCreateWireLabel(cv nil '(25.000 28.250) "D11" "lowerLeft" "R90" "stick" 0.0625 nil)
schCreatePin(cv nil "D11" "inputOutput" nil '(25.000 28.750) "R270")
schCreateWire(cv "route" "full" '((25.312 27.000) (25.312 26.250)) 0 0 0 nil nil)
schCreateWireLabel(cv nil '(25.312 26.750) "POC" "lowerRight" "R90" "stick" 0.0625 nil)
schCreateWire(cv "route" "full" '((25.125 27.000) (25.125 26.250)) 0 0 0 nil nil)
schCreateWireLabel(cv nil '(25.125 26.750) "VIOL" "lowerRight" "R90" "stick" 0.0625 nil)
schCreateWire(cv "route" "full" '((24.938 27.000) (24.938 26.250)) 0 0 0 nil nil)
schCreateWireLabel(cv nil '(24.938 26.750) "GIOL" "lowerRight" "R90" "stick" 0.0625 nil)
schCreateWire(cv "route" "full" '((24.750 27.000) (24.750 26.250)) 0 0 0 nil nil)
schCreateWireLabel(cv nil '(24.750 26.750) "VIOH" "lowerRight" "R90" "stick" 0.0625 nil)
schCreateWire(cv "route" "full" '((24.375 27.000) (24.375 26.250)) 0 0 0 nil nil)
schCreateWireLabel(cv nil '(24.375 26.750) "GIOH" "lowerRight" "R90" "stick" 0.0625 nil)
dbCreateInst(cv pddw16sdgz_v_gMaster "SCK_top1" '(23.6875 28.0) "R180")
schCreateWire(cv "route" "full" '((23.562 27.000) (23.562 26.250)) 0 0 0 nil nil)
schCreateWireLabel(cv nil '(23.562 26.750) "GIOL" "lowerRight" "R90" "stick" 0.0625 nil)
schCreateWire(cv "route" "full" '((23.438 27.000) (23.438 26.250)) 0 0 0 nil nil)
schCreateWireLabel(cv nil '(23.438 26.750) "SCK_CORE" "lowerRight" "R90" "stick" 0.0625 nil)
schCreatePin(cv nil "SCK_CORE" "inputOutput" nil '(23.438 26.250) "R90")
schCreateWire(cv "route" "full" '((23.812 27.000) (23.812 26.250)) 0 0 0 nil nil)
schCreateWireLabel(cv nil '(23.812 26.750) "VIOL" "lowerRight" "R90" "stick" 0.0625 nil)
schCreateWire(cv "route" "full" '((23.938 27.000) (23.938 26.250)) 0 0 0 nil nil)
schCreateWireLabel(cv nil '(23.938 26.750) "GIOL" "lowerRight" "R90" "stick" 0.0625 nil)
schCreateWire(cv "route" "full" '((23.000 28.000) (23.000 28.750)) 0 0 0 nil nil)
schCreateWireLabel(cv nil '(23.000 28.250) "SCK" "lowerLeft" "R90" "stick" 0.0625 nil)
schCreatePin(cv nil "SCK" "inputOutput" nil '(23.000 28.750) "R270")
schCreateWire(cv "route" "full" '((23.312 27.000) (23.312 26.250)) 0 0 0 nil nil)
schCreateWireLabel(cv nil '(23.312 26.750) "POC" "lowerRight" "R90" "stick" 0.0625 nil)
schCreateWire(cv "route" "full" '((23.125 27.000) (23.125 26.250)) 0 0 0 nil nil)
schCreateWireLabel(cv nil '(23.125 26.750) "VIOL" "lowerRight" "R90" "stick" 0.0625 nil)
schCreateWire(cv "route" "full" '((22.938 27.000) (22.938 26.250)) 0 0 0 nil nil)
schCreateWireLabel(cv nil '(22.938 26.750) "GIOL" "lowerRight" "R90" "stick" 0.0625 nil)
schCreateWire(cv "route" "full" '((22.750 27.000) (22.750 26.250)) 0 0 0 nil nil)
schCreateWireLabel(cv nil '(22.750 26.750) "VIOH" "lowerRight" "R90" "stick" 0.0625 nil)
schCreateWire(cv "route" "full" '((22.375 27.000) (22.375 26.250)) 0 0 0 nil nil)
schCreateWireLabel(cv nil '(22.375 26.750) "GIOH" "lowerRight" "R90" "stick" 0.0625 nil)
dbCreateInst(cv pddw16sdgz_v_gMaster "SDI_top2" '(21.6875 28.0) "R180")
schCreateWire(cv "route" "full" '((21.562 27.000) (21.562 26.250)) 0 0 0 nil nil)
schCreateWireLabel(cv nil '(21.562 26.750) "GIOL" "lowerRight" "R90" "stick" 0.0625 nil)
schCreateWire(cv "route" "full" '((21.438 27.000) (21.438 26.250)) 0 0 0 nil nil)
schCreateWireLabel(cv nil '(21.438 26.750) "SDI_CORE" "lowerRight" "R90" "stick" 0.0625 nil)
schCreatePin(cv nil "SDI_CORE" "inputOutput" nil '(21.438 26.250) "R90")
schCreateWire(cv "route" "full" '((21.812 27.000) (21.812 26.250)) 0 0 0 nil nil)
schCreateWireLabel(cv nil '(21.812 26.750) "VIOL" "lowerRight" "R90" "stick" 0.0625 nil)
schCreateWire(cv "route" "full" '((21.938 27.000) (21.938 26.250)) 0 0 0 nil nil)
schCreateWireLabel(cv nil '(21.938 26.750) "GIOL" "lowerRight" "R90" "stick" 0.0625 nil)
schCreateWire(cv "route" "full" '((21.000 28.000) (21.000 28.750)) 0 0 0 nil nil)
schCreateWireLabel(cv nil '(21.000 28.250) "SDI" "lowerLeft" "R90" "stick" 0.0625 nil)
schCreatePin(cv nil "SDI" "inputOutput" nil '(21.000 28.750) "R270")
schCreateWire(cv "route" "full" '((21.312 27.000) (21.312 26.250)) 0 0 0 nil nil)
schCreateWireLabel(cv nil '(21.312 26.750) "POC" "lowerRight" "R90" "stick" 0.0625 nil)
schCreateWire(cv "route" "full" '((21.125 27.000) (21.125 26.250)) 0 0 0 nil nil)
schCreateWireLabel(cv nil '(21.125 26.750) "VIOL" "lowerRight" "R90" "stick" 0.0625 nil)
schCreateWire(cv "route" "full" '((20.938 27.000) (20.938 26.250)) 0 0 0 nil nil)
schCreateWireLabel(cv nil '(20.938 26.750) "GIOL" "lowerRight" "R90" "stick" 0.0625 nil)
schCreateWire(cv "route" "full" '((20.750 27.000) (20.750 26.250)) 0 0 0 nil nil)
schCreateWireLabel(cv nil '(20.750 26.750) "VIOH" "lowerRight" "R90" "stick" 0.0625 nil)
schCreateWire(cv "route" "full" '((20.375 27.000) (20.375 26.250)) 0 0 0 nil nil)
schCreateWireLabel(cv nil '(20.375 26.750) "GIOH" "lowerRight" "R90" "stick" 0.0625 nil)
dbCreateInst(cv pddw16sdgz_v_gMaster "SDO_top3" '(19.6875 28.0) "R180")
schCreateWire(cv "route" "full" '((19.562 27.000) (19.562 26.250)) 0 0 0 nil nil)
schCreateWireLabel(cv nil '(19.562 26.750) "VIOL" "lowerRight" "R90" "stick" 0.0625 nil)
schCreateWire(cv "route" "full" '((19.438 27.000) (19.438 26.250)) 0 0 0 nil nil)
dbCreateInst(cv noConnMaster "noConn_SDO_top3_C" '(19.438 26.250) "R0")
schCreateWire(cv "route" "full" '((19.812 27.000) (19.812 26.250)) 0 0 0 nil nil)
schCreateWireLabel(cv nil '(19.812 26.750) "GIOL" "lowerRight" "R90" "stick" 0.0625 nil)
schCreateWire(cv "route" "full" '((19.938 27.000) (19.938 26.250)) 0 0 0 nil nil)
schCreateWireLabel(cv nil '(19.938 26.750) "SDO_CORE" "lowerRight" "R90" "stick" 0.0625 nil)
schCreatePin(cv nil "SDO_CORE" "inputOutput" nil '(19.938 26.250) "R90")
schCreateWire(cv "route" "full" '((19.000 28.000) (19.000 28.750)) 0 0 0 nil nil)
schCreateWireLabel(cv nil '(19.000 28.250) "SDO" "lowerLeft" "R90" "stick" 0.0625 nil)
schCreatePin(cv nil "SDO" "inputOutput" nil '(19.000 28.750) "R270")
schCreateWire(cv "route" "full" '((19.312 27.000) (19.312 26.250)) 0 0 0 nil nil)
schCreateWireLabel(cv nil '(19.312 26.750) "POC" "lowerRight" "R90" "stick" 0.0625 nil)
schCreateWire(cv "route" "full" '((19.125 27.000) (19.125 26.250)) 0 0 0 nil nil)
schCreateWireLabel(cv nil '(19.125 26.750) "VIOL" "lowerRight" "R90" "stick" 0.0625 nil)
schCreateWire(cv "route" "full" '((18.938 27.000) (18.938 26.250)) 0 0 0 nil nil)
schCreateWireLabel(cv nil '(18.938 26.750) "GIOL" "lowerRight" "R90" "stick" 0.0625 nil)
schCreateWire(cv "route" "full" '((18.750 27.000) (18.750 26.250)) 0 0 0 nil nil)
schCreateWireLabel(cv nil '(18.750 26.750) "VIOH" "lowerRight" "R90" "stick" 0.0625 nil)
schCreateWire(cv "route" "full" '((18.375 27.000) (18.375 26.250)) 0 0 0 nil nil)
schCreateWireLabel(cv nil '(18.375 26.750) "GIOH" "lowerRight" "R90" "stick" 0.0625 nil)
dbCreateInst(cv pddw16sdgz_v_gMaster "RST_top4" '(17.6875 28.0) "R180")
schCreateWire(cv "route" "full" '((17.562 27.000) (17.562 26.250)) 0 0 0 nil nil)
schCreateWireLabel(cv nil '(17.562 26.750) "GIOL" "lowerRight" "R90" "stick" 0.0625 nil)
schCreateWire(cv "route" "full" '((17.438 27.000) (17.438 26.250)) 0 0 0 nil nil)
schCreateWireLabel(cv nil '(17.438 26.750) "RST_CORE" "lowerRight" "R90" "stick" 0.0625 nil)
schCreatePin(cv nil "RST_CORE" "inputOutput" nil '(17.438 26.250) "R90")
schCreateWire(cv "route" "full" '((17.812 27.000) (17.812 26.250)) 0 0 0 nil nil)
schCreateWireLabel(cv nil '(17.812 26.750) "VIOL" "lowerRight" "R90" "stick" 0.0625 nil)
schCreateWire(cv "route" "full" '((17.938 27.000) (17.938 26.250)) 0 0 0 nil nil)
schCreateWireLabel(cv nil '(17.938 26.750) "GIOL" "lowerRight" "R90" "stick" 0.0625 nil)
schCreateWire(cv "route" "full" '((17.000 28.000) (17.000 28.750)) 0 0 0 nil nil)
schCreateWireLabel(cv nil '(17.000 28.250) "RST" "lowerLeft" "R90" "stick" 0.0625 nil)
schCreatePin(cv nil "RST" "inputOutput" nil '(17.000 28.750) "R270")
schCreateWire(cv "route" "full" '((17.312 27.000) (17.312 26.250)) 0 0 0 nil nil)
schCreateWireLabel(cv nil '(17.312 26.750) "POC" "lowerRight" "R90" "stick" 0.0625 nil)
schCreateWire(cv "route" "full" '((17.125 27.000) (17.125 26.250)) 0 0 0 nil nil)
schCreateWireLabel(cv nil '(17.125 26.750) "VIOL" "lowerRight" "R90" "stick" 0.0625 nil)
schCreateWire(cv "route" "full" '((16.938 27.000) (16.938 26.250)) 0 0 0 nil nil)
schCreateWireLabel(cv nil '(16.938 26.750) "GIOL" "lowerRight" "R90" "stick" 0.0625 nil)
schCreateWire(cv "route" "full" '((16.750 27.000) (16.750 26.250)) 0 0 0 nil nil)
schCreateWireLabel(cv nil '(16.750 26.750) "VIOH" "lowerRight" "R90" "stick" 0.0625 nil)
schCreateWire(cv "route" "full" '((16.375 27.000) (16.375 26.250)) 0 0 0 nil nil)
schCreateWireLabel(cv nil '(16.375 26.750) "GIOH" "lowerRight" "R90" "stick" 0.0625 nil)
dbCreateInst(cv pddw16sdgz_v_gMaster "SYNC_top5" '(15.6875 28.0) "R180")
schCreateWire(cv "route" "full" '((15.562 27.000) (15.562 26.250)) 0 0 0 nil nil)
schCreateWireLabel(cv nil '(15.562 26.750) "GIOL" "lowerRight" "R90" "stick" 0.0625 nil)
schCreateWire(cv "route" "full" '((15.438 27.000) (15.438 26.250)) 0 0 0 nil nil)
schCreateWireLabel(cv nil '(15.438 26.750) "SYNC_CORE" "lowerRight" "R90" "stick" 0.0625 nil)
schCreatePin(cv nil "SYNC_CORE" "inputOutput" nil '(15.438 26.250) "R90")
schCreateWire(cv "route" "full" '((15.812 27.000) (15.812 26.250)) 0 0 0 nil nil)
schCreateWireLabel(cv nil '(15.812 26.750) "VIOL" "lowerRight" "R90" "stick" 0.0625 nil)
schCreateWire(cv "route" "full" '((15.938 27.000) (15.938 26.250)) 0 0 0 nil nil)
schCreateWireLabel(cv nil '(15.938 26.750) "GIOL" "lowerRight" "R90" "stick" 0.0625 nil)
schCreateWire(cv "route" "full" '((14.999 28.000) (14.999 28.750)) 0 0 0 nil nil)
schCreateWireLabel(cv nil '(14.999 28.250) "SYNC" "lowerLeft" "R90" "stick" 0.0625 nil)
schCreatePin(cv nil "SYNC" "inputOutput" nil '(14.999 28.750) "R270")
schCreateWire(cv "route" "full" '((15.312 27.000) (15.312 26.250)) 0 0 0 nil nil)
schCreateWireLabel(cv nil '(15.312 26.750) "POC" "lowerRight" "R90" "stick" 0.0625 nil)
schCreateWire(cv "route" "full" '((15.126 27.000) (15.126 26.250)) 0 0 0 nil nil)
schCreateWireLabel(cv nil '(15.126 26.750) "VIOL" "lowerRight" "R90" "stick" 0.0625 nil)
schCreateWire(cv "route" "full" '((14.938 27.000) (14.938 26.250)) 0 0 0 nil nil)
schCreateWireLabel(cv nil '(14.938 26.750) "GIOL" "lowerRight" "R90" "stick" 0.0625 nil)
schCreateWire(cv "route" "full" '((14.749 27.000) (14.749 26.250)) 0 0 0 nil nil)
schCreateWireLabel(cv nil '(14.749 26.750) "VIOH" "lowerRight" "R90" "stick" 0.0625 nil)
schCreateWire(cv "route" "full" '((14.376 27.000) (14.376 26.250)) 0 0 0 nil nil)
schCreateWireLabel(cv nil '(14.376 26.750) "GIOH" "lowerRight" "R90" "stick" 0.0625 nil)
dbCreateInst(cv pddw16sdgz_v_gMaster "CLKO_top6" '(13.6875 28.0) "R180")
schCreateWire(cv "route" "full" '((13.562 27.000) (13.562 26.250)) 0 0 0 nil nil)
schCreateWireLabel(cv nil '(13.562 26.750) "GIOL" "lowerRight" "R90" "stick" 0.0625 nil)
schCreateWire(cv "route" "full" '((13.438 27.000) (13.438 26.250)) 0 0 0 nil nil)
schCreateWireLabel(cv nil '(13.438 26.750) "CLKO_CORE" "lowerRight" "R90" "stick" 0.0625 nil)
schCreatePin(cv nil "CLKO_CORE" "inputOutput" nil '(13.438 26.250) "R90")
schCreateWire(cv "route" "full" '((13.812 27.000) (13.812 26.250)) 0 0 0 nil nil)
schCreateWireLabel(cv nil '(13.812 26.750) "VIOL" "lowerRight" "R90" "stick" 0.0625 nil)
schCreateWire(cv "route" "full" '((13.938 27.000) (13.938 26.250)) 0 0 0 nil nil)
schCreateWireLabel(cv nil '(13.938 26.750) "GIOL" "lowerRight" "R90" "stick" 0.0625 nil)
schCreateWire(cv "route" "full" '((12.999 28.000) (12.999 28.750)) 0 0 0 nil nil)
schCreateWireLabel(cv nil '(12.999 28.250) "CLKO" "lowerLeft" "R90" "stick" 0.0625 nil)
schCreatePin(cv nil "CLKO" "inputOutput" nil '(12.999 28.750) "R270")
schCreateWire(cv "route" "full" '((13.312 27.000) (13.312 26.250)) 0 0 0 nil nil)
schCreateWireLabel(cv nil '(13.312 26.750) "POC" "lowerRight" "R90" "stick" 0.0625 nil)
schCreateWire(cv "route" "full" '((13.126 27.000) (13.126 26.250)) 0 0 0 nil nil)
schCreateWireLabel(cv nil '(13.126 26.750) "VIOL" "lowerRight" "R90" "stick" 0.0625 nil)
schCreateWire(cv "route" "full" '((12.938 27.000) (12.938 26.250)) 0 0 0 nil nil)
schCreateWireLabel(cv nil '(12.938 26.750) "GIOL" "lowerRight" "R90" "stick" 0.0625 nil)
schCreateWire(cv "route" "full" '((12.749 27.000) (12.749 26.250)) 0 0 0 nil nil)
schCreateWireLabel(cv nil '(12.749 26.750) "VIOH" "lowerRight" "R90" "stick" 0.0625 nil)
schCreateWire(cv "route" "full" '((12.376 27.000) (12.376 26.250)) 0 0 0 nil nil)
schCreateWireLabel(cv nil '(12.376 26.750) "GIOH" "lowerRight" "R90" "stick" 0.0625 nil)
dbCreateInst(cv pddw16sdgz_v_gMaster "FLAG_top7" '(11.6875 28.0) "R180")
schCreateWire(cv "route" "full" '((11.562 27.000) (11.562 26.250)) 0 0 0 nil nil)
schCreateWireLabel(cv nil '(11.562 26.750) "VIOL" "lowerRight" "R90" "stick" 0.0625 nil)
schCreateWire(cv "route" "full" '((11.438 27.000) (11.438 26.250)) 0 0 0 nil nil)
dbCreateInst(cv noConnMaster "noConn_FLAG_top7_C" '(11.438 26.250) "R0")
schCreateWire(cv "route" "full" '((11.812 27.000) (11.812 26.250)) 0 0 0 nil nil)
schCreateWireLabel(cv nil '(11.812 26.750) "GIOL" "lowerRight" "R90" "stick" 0.0625 nil)
schCreateWire(cv "route" "full" '((11.938 27.000) (11.938 26.250)) 0 0 0 nil nil)
schCreateWireLabel(cv nil '(11.938 26.750) "FLAG_CORE" "lowerRight" "R90" "stick" 0.0625 nil)
schCreatePin(cv nil "FLAG_CORE" "inputOutput" nil '(11.938 26.250) "R90")
schCreateWire(cv "route" "full" '((10.999 28.000) (10.999 28.750)) 0 0 0 nil nil)
schCreateWireLabel(cv nil '(10.999 28.250) "FLAG" "lowerLeft" "R90" "stick" 0.0625 nil)
schCreatePin(cv nil "FLAG" "inputOutput" nil '(10.999 28.750) "R270")
schCreateWire(cv "route" "full" '((11.312 27.000) (11.312 26.250)) 0 0 0 nil nil)
schCreateWireLabel(cv nil '(11.312 26.750) "POC" "lowerRight" "R90" "stick" 0.0625 nil)
schCreateWire(cv "route" "full" '((11.126 27.000) (11.126 26.250)) 0 0 0 nil nil)
schCreateWireLabel(cv nil '(11.126 26.750) "VIOL" "lowerRight" "R90" "stick" 0.0625 nil)
schCreateWire(cv "route" "full" '((10.938 27.000) (10.938 26.250)) 0 0 0 nil nil)
schCreateWireLabel(cv nil '(10.938 26.750) "GIOL" "lowerRight" "R90" "stick" 0.0625 nil)
schCreateWire(cv "route" "full" '((10.749 27.000) (10.749 26.250)) 0 0 0 nil nil)
schCreateWireLabel(cv nil '(10.749 26.750) "VIOH" "lowerRight" "R90" "stick" 0.0625 nil)
schCreateWire(cv "route" "full" '((10.376 27.000) (10.376 26.250)) 0 0 0 nil nil)
schCreateWireLabel(cv nil '(10.376 26.750) "GIOH" "lowerRight" "R90" "stick" 0.0625 nil)
pvss1dgz_v_gMaster = dbOpenCellView("tphn28hpcpgv18" "PVSS1DGZ_V_G" "symbol")
dbCreateInst(cv pvss1dgz_v_gMaster "GIOL_top8" '(10.0 28.0) "R180")
schCreateWire(cv "route" "full" '((9.625 27.000) (9.625 26.250)) 0 0 0 nil nil)
schCreateWireLabel(cv nil '(9.625 26.750) "POC" "lowerRight" "R90" "stick" 0.0625 nil)
schCreateWire(cv "route" "full" '((9.438 27.000) (9.438 26.250)) 0 0 0 nil nil)
schCreateWireLabel(cv nil '(9.438 26.750) "VIOL" "lowerRight" "R90" "stick" 0.0625 nil)
schCreateWire(cv "route" "full" '((9.000 28.000) (9.000 28.750)) 0 0 0 nil nil)
schCreateWireLabel(cv nil '(9.000 28.250) "GIOL" "lowerLeft" "R90" "stick" 0.0625 nil)
schCreatePin(cv nil "GIOL" "inputOutput" nil '(9.000 28.750) "R270")
schCreateWire(cv "route" "full" '((9.062 27.000) (9.062 26.250)) 0 0 0 nil nil)
schCreateWireLabel(cv nil '(9.062 26.750) "VIOH" "lowerRight" "R90" "stick" 0.0625 nil)
schCreateWire(cv "route" "full" '((8.688 27.000) (8.688 26.250)) 0 0 0 nil nil)
schCreateWireLabel(cv nil '(8.688 26.750) "GIOH" "lowerRight" "R90" "stick" 0.0625 nil)
pvdd1dgz_v_gMaster = dbOpenCellView("tphn28hpcpgv18" "PVDD1DGZ_V_G" "symbol")
dbCreateInst(cv pvdd1dgz_v_gMaster "VIOL_top9" '(8.0 28.0) "R180")
schCreateWire(cv "route" "full" '((7.625 27.000) (7.625 26.250)) 0 0 0 nil nil)
schCreateWireLabel(cv nil '(7.625 26.750) "POC" "lowerRight" "R90" "stick" 0.0625 nil)
schCreateWire(cv "route" "full" '((7.000 28.000) (7.000 28.750)) 0 0 0 nil nil)
schCreateWireLabel(cv nil '(7.000 28.250) "VIOL" "lowerLeft" "R90" "stick" 0.0625 nil)
schCreatePin(cv nil "VIOL" "inputOutput" nil '(7.000 28.750) "R270")
schCreateWire(cv "route" "full" '((7.250 27.000) (7.250 26.250)) 0 0 0 nil nil)
schCreateWireLabel(cv nil '(7.250 26.750) "GIOL" "lowerRight" "R90" "stick" 0.0625 nil)
schCreateWire(cv "route" "full" '((7.062 27.000) (7.062 26.250)) 0 0 0 nil nil)
schCreateWireLabel(cv nil '(7.062 26.750) "VIOH" "lowerRight" "R90" "stick" 0.0625 nil)
schCreateWire(cv "route" "full" '((6.688 27.000) (6.688 26.250)) 0 0 0 nil nil)
schCreateWireLabel(cv nil '(6.688 26.750) "GIOH" "lowerRight" "R90" "stick" 0.0625 nil)
pvss2dgz_v_gMaster = dbOpenCellView("tphn28hpcpgv18" "PVSS2DGZ_V_G" "symbol")
dbCreateInst(cv pvss2dgz_v_gMaster "GIOH_top10" '(6.0 28.0) "R180")
schCreateWire(cv "route" "full" '((5.625 27.000) (5.625 26.250)) 0 0 0 nil nil)
schCreateWireLabel(cv nil '(5.625 26.750) "POC" "lowerRight" "R90" "stick" 0.0625 nil)
schCreateWire(cv "route" "full" '((5.438 27.000) (5.438 26.250)) 0 0 0 nil nil)
schCreateWireLabel(cv nil '(5.438 26.750) "VIOL" "lowerRight" "R90" "stick" 0.0625 nil)
schCreateWire(cv "route" "full" '((5.250 27.000) (5.250 26.250)) 0 0 0 nil nil)
schCreateWireLabel(cv nil '(5.250 26.750) "GIOL" "lowerRight" "R90" "stick" 0.0625 nil)
schCreateWire(cv "route" "full" '((5.062 27.000) (5.062 26.250)) 0 0 0 nil nil)
schCreateWireLabel(cv nil '(5.062 26.750) "VIOH" "lowerRight" "R90" "stick" 0.0625 nil)
schCreateWire(cv "route" "full" '((5.000 28.000) (5.000 28.750)) 0 0 0 nil nil)
schCreateWireLabel(cv nil '(5.000 28.250) "GIOH" "lowerLeft" "R90" "stick" 0.0625 nil)
schCreatePin(cv nil "GIOH" "inputOutput" nil '(5.000 28.750) "R270")
pvdd2poc_v_gMaster = dbOpenCellView("tphn28hpcpgv18" "PVDD2POC_V_G" "symbol")
dbCreateInst(cv pvdd2poc_v_gMaster "VIOH_top11" '(4.0 28.0) "R180")
schCreateWire(cv "route" "full" '((3.625 27.000) (3.625 26.250)) 0 0 0 nil nil)
schCreateWireLabel(cv nil '(3.625 26.750) "POC" "lowerRight" "R90" "stick" 0.0625 nil)
schCreateWire(cv "route" "full" '((3.438 27.000) (3.438 26.250)) 0 0 0 nil nil)
schCreateWireLabel(cv nil '(3.438 26.750) "VIOL" "lowerRight" "R90" "stick" 0.0625 nil)
schCreateWire(cv "route" "full" '((3.250 27.000) (3.250 26.250)) 0 0 0 nil nil)
schCreateWireLabel(cv nil '(3.250 26.750) "GIOL" "lowerRight" "R90" "stick" 0.0625 nil)
schCreateWire(cv "route" "full" '((3.000 28.000) (3.000 28.750)) 0 0 0 nil nil)
schCreateWireLabel(cv nil '(3.000 28.250) "VIOH" "lowerLeft" "R90" "stick" 0.0625 nil)
schCreatePin(cv nil "VIOH" "inputOutput" nil '(3.000 28.750) "R270")
schCreateWire(cv "route" "full" '((2.688 27.000) (2.688 26.250)) 0 0 0 nil nil)
schCreateWireLabel(cv nil '(2.688 26.750) "GIOH" "lowerRight" "R90" "stick" 0.0625 nil)
dbCreateInst(cv pddw16sdgz_h_gMaster "D12_right1011" '(24.0 22.625) "R90")
schCreateWire(cv "route" "full" '((23.000 22.750) (22.250 22.750)) 0 0 0 nil nil)
schCreateWireLabel(cv nil '(22.750 22.750) "VIOL" "lowerRight" "R0" "stick" 0.0625 nil)
schCreateWire(cv "route" "full" '((23.000 22.875) (22.250 22.875)) 0 0 0 nil nil)
dbCreateInst(cv noConnMaster "noConn_D12_right1011_C" '(22.250 22.875) "R270")
schCreateWire(cv "route" "full" '((23.000 22.500) (22.250 22.500)) 0 0 0 nil nil)
schCreateWireLabel(cv nil '(22.750 22.500) "GIOL" "lowerRight" "R0" "stick" 0.0625 nil)
schCreateWire(cv "route" "full" '((23.000 22.375) (22.250 22.375)) 0 0 0 nil nil)
schCreateWireLabel(cv nil '(22.750 22.375) "D12_CORE" "lowerRight" "R0" "stick" 0.0625 nil)
schCreatePin(cv nil "D12_CORE" "inputOutput" nil '(22.250 22.375) "R0")
schCreateWire(cv "route" "full" '((24.000 23.313) (24.750 23.313)) 0 0 0 nil nil)
schCreateWireLabel(cv nil '(24.250 23.313) "D12" "lowerLeft" "R0" "stick" 0.0625 nil)
schCreatePin(cv nil "D12" "inputOutput" nil '(24.750 23.313) "R180")
schCreateWire(cv "route" "full" '((23.000 23.000) (22.250 23.000)) 0 0 0 nil nil)
schCreateWireLabel(cv nil '(22.750 23.000) "POC" "lowerRight" "R0" "stick" 0.0625 nil)
schCreateWire(cv "route" "full" '((23.000 23.187) (22.250 23.187)) 0 0 0 nil nil)
schCreateWireLabel(cv nil '(22.750 23.187) "VIOL" "lowerRight" "R0" "stick" 0.0625 nil)
schCreateWire(cv "route" "full" '((23.000 23.375) (22.250 23.375)) 0 0 0 nil nil)
schCreateWireLabel(cv nil '(22.750 23.375) "GIOL" "lowerRight" "R0" "stick" 0.0625 nil)
schCreateWire(cv "route" "full" '((23.000 23.563) (22.250 23.563)) 0 0 0 nil nil)
schCreateWireLabel(cv nil '(22.750 23.563) "VIOH" "lowerRight" "R0" "stick" 0.0625 nil)
schCreateWire(cv "route" "full" '((23.000 23.937) (22.250 23.937)) 0 0 0 nil nil)
schCreateWireLabel(cv nil '(22.750 23.937) "GIOH" "lowerRight" "R0" "stick" 0.0625 nil)
dbCreateInst(cv pdb3ac_h_gMaster "VCM1_left56" '(4.0 13.625) "R270")
schCreateWire(cv "route" "full" '((4.000 13.813) (3.250 13.813)) 0 0 0 nil nil)
schCreateWireLabel(cv nil '(3.750 13.813) "VCM1" "lowerRight" "R0" "stick" 0.0625 nil)
schCreatePin(cv nil "VCM1" "inputOutput" nil '(3.250 13.813) "R0")
schCreateWire(cv "route" "full" '((4.875 13.875) (5.625 13.875)) 0 0 0 nil nil)
schCreateWireLabel(cv nil '(5.125 13.875) "AVSS" "lowerLeft" "R0" "stick" 0.0625 nil)
schCreateWire(cv "route" "full" '((4.875 13.500) (5.625 13.500)) 0 0 0 nil nil)
schCreateWireLabel(cv nil '(5.125 13.500) "GIOL" "lowerLeft" "R0" "stick" 0.0625 nil)
schCreateWire(cv "route" "full" '((4.875 14.250) (5.625 14.250)) 0 0 0 nil nil)
schCreateWireLabel(cv nil '(5.125 14.250) "AVDD" "lowerLeft" "R0" "stick" 0.0625 nil)
schCheck(cv)
dbSave(cv)
t
